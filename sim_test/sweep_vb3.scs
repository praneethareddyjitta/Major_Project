simulator lang=spectre
include "/home/install/FOUNDRY/analog/180nm/models/spectre/gpdk.scs" section=NN
include "/home/STUDENT/Documents/163_majorproject/sim_test/rfc_ota_test.scs"

swp dc dev=Vb3 start=0.4 stop=0.85 step=0.01
